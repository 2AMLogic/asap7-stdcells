* extracted by klt extract --deck asap7

* cell OAI22x1_A7S_75t_R
* pin A1
* pin A2
* pin B1
* pin B2
* pin VDD
* pin VSS
* pin Y
* pin vsubs
.SUBCKT OAI22x1_A7S_75t_R A1 A2 B1 B2 VDD VSS Y vsubs
* device instance $1 r0 *1 0,0.018 nmos_rvt
M$1 Y A1 \$7 vsubs nmos_rvt L=0.02U W=0.081U NFIN=3
* device instance $2 r0 *1 0,0.018 nmos_rvt
M$2 \$7 A2 Y vsubs nmos_rvt L=0.02U W=0.081U NFIN=3
* device instance $3 r0 *1 0,0.018 nmos_rvt
M$3 VSS B2 \$7 vsubs nmos_rvt L=0.02U W=0.081U NFIN=3
* device instance $4 r0 *1 0,0.018 nmos_rvt
M$4 \$7 B1 VSS vsubs nmos_rvt L=0.02U W=0.081U NFIN=3
* device instance $5 r0 *1 0,0.018 pmos_rvt
M$5 \$17 A1 Y \$9 pmos_rvt L=0.02U W=0.081U NFIN=3
* device instance $6 r0 *1 0,0.018 pmos_rvt
M$6 VDD A2 \$17 \$9 pmos_rvt L=0.02U W=0.081U NFIN=3
* device instance $7 r0 *1 0,0.018 pmos_rvt
M$7 \$16 B2 VDD \$9 pmos_rvt L=0.02U W=0.081U NFIN=3
* device instance $8 r0 *1 0,0.018 pmos_rvt
M$8 Y B1 \$16 \$9 pmos_rvt L=0.02U W=0.081U NFIN=3
.ENDS OAI22x1_A7S_75t_R
