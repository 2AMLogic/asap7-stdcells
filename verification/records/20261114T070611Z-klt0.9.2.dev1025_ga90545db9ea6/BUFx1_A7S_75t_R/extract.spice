* extracted by klt extract --deck asap7

* cell BUFx1_A7S_75t_R
* pin A
* pin VDD
* pin VSS
* pin Y
* pin vsubs
.SUBCKT BUFx1_A7S_75t_R A VDD VSS Y vsubs
* device instance $1 r0 *1 0,0.018 nmos_rvt
M$1 VSS A \$5 vsubs nmos_rvt L=0.02U W=0.081U NFIN=3
* device instance $2 r0 *1 0,0.018 nmos_rvt
M$2 Y \$5 VSS vsubs nmos_rvt L=0.02U W=0.081U NFIN=3
* device instance $3 r0 *1 0,0.018 pmos_rvt
M$3 VDD A \$5 \$6 pmos_rvt L=0.02U W=0.081U NFIN=3
* device instance $4 r0 *1 0,0.018 pmos_rvt
M$4 Y \$5 VDD \$6 pmos_rvt L=0.02U W=0.081U NFIN=3
.ENDS BUFx1_A7S_75t_R
