* OAI21x1 corner testbench (decision 0011); a predictive-model run, not a measured part.
.include OAI21x1.osdi.spice
vsup vdd 0 DC 0.7
Xdut in_a1 in_a2 in_b vdd 0 y 0 OAI21x1_A7S_75t_R
Cload y 0 1.440000e-15
Bylvl ylvl 0 V='v(y)/v(vdd)'
Bymid ymid 0 V='v(y)-0.5*v(vdd)'
Bimid_a1 imid_a1 0 V='v(in_a1)-0.5*v(vdd)'
Bimid_a2 imid_a2 0 V='v(in_a2)-0.5*v(vdd)'
Bimid_b imid_b 0 V='v(in_b)-0.5*v(vdd)'
