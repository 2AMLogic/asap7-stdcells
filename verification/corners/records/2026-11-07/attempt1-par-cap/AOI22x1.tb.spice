* AOI22x1 corner testbench (decision 0011); a predictive-model run, not a measured part.
.include AOI22x1.osdi.spice
vsup vdd 0 DC 0.7
Xdut in_a1 in_a2 in_b1 in_b2 vdd 0 y 0 AOI22x1_A7S_75t_R
Cload y 0 1.440000e-15
