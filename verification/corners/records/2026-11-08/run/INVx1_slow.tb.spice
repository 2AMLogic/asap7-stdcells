* INVx1 corner testbench (decision 0011); a predictive-model run, not a measured part.
.include INVx1_slow.osdi.spice
vsup vdd 0 DC 0.7
Xdut in_a vdd 0 y 0 INVx1_slow_A7S_75t_R
Cload y 0 1.440000e-15
Bylvl ylvl 0 V='v(y)/v(vdd)'
Bymid ymid 0 V='v(y)-0.5*v(vdd)'
Bimid_a imid_a 0 V='v(in_a)-0.5*v(vdd)'
