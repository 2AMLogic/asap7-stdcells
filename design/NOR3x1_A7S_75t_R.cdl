* NOR3x1_A7S_75t_R: Y = !(A | B | C). Hand-written; topology as it will be drawn (static CMOS,
* parallel NMOS, series PMOS A, B, C from the output).
* NFIN=3 per device (unit-drive rule of spec/stdcells.md, w=81.0n as in the
* INVx1 CDL); fin counts are revisited in the cell's layout PR, which edits
* this file and re-pairs it in design/cdl-freshness.json. Predictive-PDK
* netlist; nothing here is a measured part.
.SUBCKT NOR3x1_A7S_75t_R A B C VDD VSS Y
MM0 Y A VSS VSS nmos_rvt w=81.0n l=20n nfin=3
MM1 Y B VSS VSS nmos_rvt w=81.0n l=20n nfin=3
MM2 Y C VSS VSS nmos_rvt w=81.0n l=20n nfin=3
MM3 Y A Y_p1 VDD pmos_rvt w=81.0n l=20n nfin=3
MM4 Y_p1 B Y_p2 VDD pmos_rvt w=81.0n l=20n nfin=3
MM5 Y_p2 C VDD VDD pmos_rvt w=81.0n l=20n nfin=3
.ENDS
