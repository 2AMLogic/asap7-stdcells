* INVx1_A7S_75t_R: Y = !A. Hand-written; the topology drawn in
* design/draw_INVx1_A7S_75t_R.py (one NMOS, one PMOS, three fins each).
* NFIN=3 per device is the unit-drive rule of spec/stdcells.md; w follows the
* shipped CDL convention for the same fin count (27 nm fin pitch + 7 nm fin
* width, 3 fins). Predictive-PDK netlist; nothing here is a measured part.
.SUBCKT INVx1_A7S_75t_R A VDD VSS Y
MM0 Y A VSS VSS nmos_rvt w=81.0n l=20n nfin=3
MM1 Y A VDD VDD pmos_rvt w=81.0n l=20n nfin=3
.ENDS
