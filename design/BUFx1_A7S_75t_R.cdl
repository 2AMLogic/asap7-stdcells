* BUFx1_A7S_75t_R: Y = A. Hand-written; topology as it will be drawn (static CMOS,
* two inverters, A -> n1 -> Y).
* NFIN=3 per device (unit-drive rule of spec/stdcells.md, w=81.0n as in the
* INVx1 CDL); fin counts are revisited in the cell's layout PR, which edits
* this file and re-pairs it in design/cdl-freshness.json. Predictive-PDK
* netlist; nothing here is a measured part.
.SUBCKT BUFx1_A7S_75t_R A VDD VSS Y
MM0 n1 A VSS VSS nmos_rvt w=81.0n l=20n nfin=3
MM1 n1 A VDD VDD pmos_rvt w=81.0n l=20n nfin=3
MM2 Y n1 VSS VSS nmos_rvt w=81.0n l=20n nfin=3
MM3 Y n1 VDD VDD pmos_rvt w=81.0n l=20n nfin=3
.ENDS
