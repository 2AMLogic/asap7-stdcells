* AND2x1_A7S_75t_R: Y = A & B. Hand-written; the topology drawn in
* design/draw_AND2x1_A7S_75t_R.py (NAND2 (ynand) then an inverter, one transistor pair per diffusion span).
* NFIN=3 per device is the unit-drive rule of spec/stdcells.md; w follows the
* shipped CDL convention for the same fin count (27 nm fin pitch + 7 nm fin
* width, 3 fins). Predictive-PDK netlist; nothing here is a measured part.
.SUBCKT AND2x1_A7S_75t_R A B VDD VSS Y
MM0 ynand A n1 VSS nmos_rvt w=81.0n l=20n nfin=3
MM1 n1 B VSS VSS nmos_rvt w=81.0n l=20n nfin=3
MM2 Y ynand VSS VSS nmos_rvt w=81.0n l=20n nfin=3
MM3 ynand A VDD VDD pmos_rvt w=81.0n l=20n nfin=3
MM4 ynand B VDD VDD pmos_rvt w=81.0n l=20n nfin=3
MM5 Y ynand VDD VDD pmos_rvt w=81.0n l=20n nfin=3
.ENDS
