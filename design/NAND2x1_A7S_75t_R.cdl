* NAND2x1_A7S_75t_R: Y = !(A & B). Hand-written; the topology drawn in
* design/draw_NAND2x1_A7S_75t_R.py (NMOS series VSS-A-n1-B-Y, PMOS parallel).
* NFIN=3 per device is the unit-drive rule of spec/stdcells.md; w follows the
* shipped CDL convention for the same fin count (27 nm fin pitch + 7 nm fin
* width, 3 fins). Predictive-PDK netlist; nothing here is a measured part.
.SUBCKT NAND2x1_A7S_75t_R A B VDD VSS Y
MM0 n1 A VSS VSS nmos_rvt w=81.0n l=20n nfin=3
MM1 Y B n1 VSS nmos_rvt w=81.0n l=20n nfin=3
MM2 Y A VDD VDD pmos_rvt w=81.0n l=20n nfin=3
MM3 Y B VDD VDD pmos_rvt w=81.0n l=20n nfin=3
.ENDS
