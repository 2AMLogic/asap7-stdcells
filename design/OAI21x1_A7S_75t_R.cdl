* OAI21x1_A7S_75t_R: Y = !((A1 | A2) & B). Hand-written; the topology drawn in
* design/draw_OAI21x1_A7S_75t_R.py (gate order B, A1, A2; one transistor pair per diffusion span).
* NFIN=3 per device is the unit-drive rule of spec/stdcells.md; w follows the
* shipped CDL convention for the same fin count (27 nm fin pitch + 7 nm fin
* width, 3 fins). Predictive-PDK netlist; nothing here is a measured part.
.SUBCKT OAI21x1_A7S_75t_R A1 A2 B VDD VSS Y
MM0 Y B n1 VSS nmos_rvt w=81.0n l=20n nfin=3
MM1 n1 A1 VSS VSS nmos_rvt w=81.0n l=20n nfin=3
MM2 n1 A2 VSS VSS nmos_rvt w=81.0n l=20n nfin=3
MM3 Y B VDD VDD pmos_rvt w=81.0n l=20n nfin=3
MM4 Y A1 p1 VDD pmos_rvt w=81.0n l=20n nfin=3
MM5 p1 A2 VDD VDD pmos_rvt w=81.0n l=20n nfin=3
.ENDS
