* TIELOx1_A7S_75t_R: L = 0. Hand-written; topology as it will be drawn (static CMOS,
* one NMOS, source VSS, gate tied to VDD (always on)).
* NFIN=3 per device (unit-drive rule of spec/stdcells.md, w=81.0n as in the
* INVx1 CDL); fin counts are revisited in the cell's layout PR, which edits
* this file and re-pairs it in design/cdl-freshness.json. Predictive-PDK
* netlist; nothing here is a measured part.
.SUBCKT TIELOx1_A7S_75t_R L VDD VSS
MM0 L VDD VSS VSS nmos_rvt w=81.0n l=20n nfin=3
.ENDS
