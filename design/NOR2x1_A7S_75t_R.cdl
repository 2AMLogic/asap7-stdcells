* NOR2x1_A7S_75t_R: Y = !(A | B). Hand-written; the topology drawn in
* design/draw_NOR2x1_A7S_75t_R.py (NMOS parallel, PMOS series VDD-A-p1-B-Y).
* NFIN=3 per device is the unit-drive rule of spec/stdcells.md; w follows the
* shipped CDL convention for the same fin count (27 nm fin pitch + 7 nm fin
* width, 3 fins). Predictive-PDK netlist; nothing here is a measured part.
.SUBCKT NOR2x1_A7S_75t_R A B VDD VSS Y
MM0 Y A VSS VSS nmos_rvt w=81.0n l=20n nfin=3
MM1 Y B VSS VSS nmos_rvt w=81.0n l=20n nfin=3
MM2 p1 A VDD VDD pmos_rvt w=81.0n l=20n nfin=3
MM3 Y B p1 VDD pmos_rvt w=81.0n l=20n nfin=3
.ENDS
